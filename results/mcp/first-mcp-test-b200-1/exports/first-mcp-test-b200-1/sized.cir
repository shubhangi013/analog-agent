Five-transistor OTA: differential AC input of 1 V, load 1 pF
.include "ptm180.lib"
.temp 27
.options numdgt=15
.param diffusion=0.18u
Vdd vdd 0 1.8
Vip inp 0 DC 0.9 AC 0.5
Vin inn 0 DC 0.9 AC 0.5 180
Vbias bias 0 0
Vsense tail tail_d 0
M1 mirror inp tail 0 NMOS W=14u L=0.6u AD={14u*diffusion} AS={14u*diffusion} PD={2*(14u+diffusion)} PS={2*(14u+diffusion)}
M2 out inn tail 0 NMOS W=14u L=0.6u AD={14u*diffusion} AS={14u*diffusion} PD={2*(14u+diffusion)} PS={2*(14u+diffusion)}
M3 mirror mirror vdd vdd PMOS W=12u L=1.2u AD={12u*diffusion} AS={12u*diffusion} PD={2*(12u+diffusion)} PS={2*(12u+diffusion)}
M4 out mirror vdd vdd PMOS W=12u L=1.2u AD={12u*diffusion} AS={12u*diffusion} PD={2*(12u+diffusion)} PS={2*(12u+diffusion)}
M5 tail_d bias 0 0 NMOS W=16u L=0.6u AD={16u*diffusion} AS={16u*diffusion} PD={2*(16u+diffusion)} PS={2*(16u+diffusion)}
Cload out 0 1p
.control
set noaskquit
set wr_singlescale
set numdgt=15
dc Vbias 0 1.8 0.001
meas dc bias_voltage FIND v(bias) WHEN i(Vsense)=2.6e-05 CROSS=1
alter Vbias $&bias_voltage
op
wrdata op.tsv v(out) v(bias) i(Vdd) i(Vsense) @m1[vds] @m1[vdsat] @m1[vgs] @m1[vth] @m1[id] @m2[vds] @m2[vdsat] @m2[vgs] @m2[vth] @m2[id] @m3[vds] @m3[vdsat] @m3[vgs] @m3[vth] @m3[id] @m4[vds] @m4[vdsat] @m4[vgs] @m4[vth] @m4[id] @m5[vds] @m5[vdsat] @m5[vgs] @m5[vth] @m5[id]
wrdata nodes.tsv v(bias) v(inn) v(inp) v(mirror) v(out) v(tail) v(tail_d) v(vdd)
ac dec 100 1 10G
wrdata ac.tsv v(out)
quit
.endc
.end
